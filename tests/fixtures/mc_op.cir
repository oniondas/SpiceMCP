* golden: 30-run Monte Carlo in ONE LTspice launch. mc(nom,tol) redraws per .step run,
* which is why robustness.evaluate_monte_carlo does not launch 30 subprocesses.
* mc() is UNIFORM over +-tol (measured over 400 runs: sd = 0.572% for tol=1%, which is
* 1/sqrt(3); a gaussian sigma=1% would read 1.0% and put 32% of samples outside +-1%).
* RA, RB are independent 1k +-1%. V(out) = RB/(RA+RB), so RA = 1k*(1/V(out) - 1) when
* RB is the 1k leg -- but RB is random too, so the fixture asserts bounds, not values.
* R3/R4 are a fixed divider: V(mid) must read exactly 0.5 in every run.
.param RA = {mc(1k,0.01)}
.param RB = {mc(1k,0.01)}
V1 in 0 1
R1 in out {RA}
R2 out 0 {RB}
R3 in mid 1k
R4 mid 0 1k
.step param run 1 30 1
.op
.end
