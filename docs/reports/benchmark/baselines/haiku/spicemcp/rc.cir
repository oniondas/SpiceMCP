* RC low-pass, fc 1 kHz (SpiceMCP run rc1, candidate cand_0035)
* R1 E96 1 %, C1 E12 5 %
V1 in 0 AC 1
R1 in out 13300
C1 out 0 12n
.ac dec 100 1 1e+06
.meas AC fc WHEN mag(V(out))=0.7071 FALL=1
.end
