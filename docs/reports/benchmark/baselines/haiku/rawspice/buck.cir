* Buck converter 12 V -> 5 V, 1 A, 500 kHz voltage-mode PWM with type-II error amp
* Sawtooth 0..1 V at 500 kHz (ideal source), comparator CMP as PWM, OPAMP2M error amp,
* soft-start reference ramp, diode clamp on error-amp output (anti-windup).
.include parts.lib
* power stage
Vin vin 0 12
S1 vin sw ctl 0 SWM
.model SWM SW(RON=10m ROFF=1Meg VT=6 VH=0.1)
D1 0 sw DMOD
.model DMOD D(IS=1u N=1 RS=20m BV=40)
L1 sw lx 100u
RDCR lx out 10m
CO nc 0 4.7u
RESR out nc 10m
RL out 0 5
* feedback divider Rt/Rb and input resistor, all 4.75k (Vout = 2 x Vref at DC)
RT out fbm 4.75k
RB fbm 0 4.75k
RIN fbm ein 4.75k
* soft-start reference ramp 0 -> 2.5 V in 0.6 ms
Vref ref 0 PULSE(0 2.5 0 0.6m 1n 1 2)
* type-II error amp: Zf = (Rf + Cf) || Cp
RF ein n1 1k
CF n1 ec 150n
CP ein ec 39n
XEA ref ein vin 0 ec OPAMP2M
* PWM: ramp 0..1 V at 500 kHz, comparator to gate drive
VSAW saw 0 PULSE(0 1 0 1.98u 10n 1n 2u)
XPWM ec saw vin 0 ctl CMP
* anti-windup clamp: error-amp output limited to about 0.7 V during start-up
Vcl clx 0 0.3
DCL ec clx DCLAMP
.model DCLAMP D(IS=1e-12 N=1)
.end
