.include parts.lib
V1 in 0 DC 0 AC 1
R1 in out 59k
C1 out 0 2.7n
